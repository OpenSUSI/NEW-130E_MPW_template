* OpenSUSI TR-1um OSS_FRAME ESD/IO Pad Subcircuits for LVS

.SUBCKT OSS_DRV OUT HIZ vdd \$16 \$17 GND|gnd
* device instance $1 r0 *1 47.8,13.5 PMOS
M$1 \$17 \$13 vdd vdd PMOS L=1u W=20.8u AS=56.68p AD=58.24p PS=47u PD=52.8u
* device instance $2 r0 *1 -37.2,5.3 PMOS
M$2 \$14 HIZ \$12 vdd PMOS L=1u W=10.4u AS=29.12p AD=6.24p PS=26.4u PD=11.6u
* device instance $3 r0 *1 -37.2,7.5 PMOS
M$3 vdd \$8 \$14 vdd PMOS L=1u W=10.4u AS=6.24p AD=26p PS=11.6u PD=15.4u
* device instance $4 r0 *1 -37.2,13.5 PMOS
M$4 \$16 \$12 vdd vdd PMOS L=1u W=20.8u AS=55.12p AD=58.24p PS=41.8u PD=52.8u
* device instance $6 r0 *1 34.6,-0.5 PMOS
M$6 vdd HIZ \$6 vdd PMOS L=1u W=5.2u AS=14.56p AD=7.8p PS=16u PD=8.2u
* device instance $7 r0 *1 34.6,3.5 PMOS
M$7 \$13 \$6 vdd vdd PMOS L=1u W=5.2u AS=7.8p AD=7.8p PS=8.2u PD=8.2u
* device instance $8 r0 *1 34.6,7.5 PMOS
M$8 vdd \$8 \$13 vdd PMOS L=1u W=5.2u AS=7.8p AD=13p PS=8.2u PD=10.2u
* device instance $10 r0 *1 -46.4,-0.5 PMOS
M$10 vdd OUT \$8 vdd PMOS L=1u W=5.2u AS=14.56p AD=22.36p PS=16u PD=19u
* device instance $11 r0 *1 8.5,13.5 NMOS
M$11 \$17 \$13 GND|gnd GND|gnd NMOS L=1u W=6.8u AS=18.02p AD=19.04p PS=20.8u
+ PD=24.8u
* device instance $12 r0 *1 -8.5,13.5 NMOS
M$12 \$16 \$12 GND|gnd GND|gnd NMOS L=1u W=6.8u AS=18.02p AD=19.04p PS=20.8u
+ PD=24.8u
* device instance $13 r0 *1 -13.3,-0.5 NMOS
M$13 GND|gnd OUT \$8 GND|gnd NMOS L=1u W=3.4u AS=9.52p AD=5.1p PS=12.4u PD=6.4u
* device instance $14 r0 *1 -13.3,3.5 NMOS
M$14 \$12 HIZ GND|gnd GND|gnd NMOS L=1u W=3.4u AS=5.1p AD=5.1p PS=6.4u PD=6.4u
* device instance $15 r0 *1 -13.3,7.5 NMOS
M$15 GND|gnd \$8 \$12 GND|gnd NMOS L=1u W=3.4u AS=5.1p AD=8.5p PS=6.4u PD=8.4u
* device instance $17 r0 *1 13.3,5.3 NMOS
M$17 \$15 \$6 \$13 GND|gnd NMOS L=1u W=3.4u AS=9.52p AD=2.04p PS=12.4u PD=4.6u
* device instance $18 r0 *1 13.3,7.5 NMOS
M$18 GND|gnd \$8 \$15 GND|gnd NMOS L=1u W=3.4u AS=2.04p AD=8.5p PS=4.6u PD=8.4u
* device instance $20 r0 *1 8.5,-0.5 NMOS
M$20 GND|gnd HIZ \$6 GND|gnd NMOS L=1u W=3.4u AS=9.52p AD=9.52p PS=12.4u
+ PD=12.4u
* device instance $21 r0 *1 -13.2,-8.4 DN
D$21 GND|gnd OUT DN A=12.96p P=14.4u
* device instance $22 r0 *1 8.6,-8.4 DN
D$22 GND|gnd HIZ DN A=12.96p P=14.4u
.ENDS OSS_DRV

.SUBCKT OSS_ESD_5V_DIO PAD VDD HIZ OUT VSS
* cell instance $1 r90 *1 -130,0
X$1 PAD VDD \$10 OSS_PCH_DRV
* cell instance $2 r90 *1 130,0
X$2 PAD \$8 VSS OSS_NCH_DRV
* cell instance $5 m0 *1 0,107.8
X$5 OUT HIZ VDD \$10 \$8 VSS OSS_DRV
.ENDS OSS_ESD_5V_DIO

.SUBCKT OSS_ESD_5V_VDD PAD|VDD VSS
* cell instance $1 r270 *1 -130,0
X$1 VSS PAD|VDD OSS_PCH_ESD
* cell instance $3 r90 *1 130,0
X$3 PAD|VDD VSS OSS_NCH_ESD
.ENDS OSS_ESD_5V_VDD

.SUBCKT OSS_ESD_5V_VSS VDD PAD|VSS
* cell instance $1 r270 *1 130,0
X$1 VDD PAD|VSS OSS_NCH_ESD
* cell instance $2 r90 *1 -130,0
X$2 PAD|VSS VDD OSS_PCH_ESD
.ENDS OSS_ESD_5V_VSS

.SUBCKT OSS_NCH_DRV PAD \$14 VSS
* device instance $1 r0 *1 -65.5,0 NMOSE
M$1 VSS VSS PAD VSS NMOSE L=2u W=350u AS=2648.04p AD=2175p PS=504.36u PD=437u
* device instance $8 r0 *1 35.5,0 NMOSE
M$8 PAD \$14 VSS VSS NMOSE L=2u W=150u AS=875p AD=1348.04p PS=185u PD=252.36u
.ENDS OSS_NCH_DRV

.SUBCKT OSS_NCH_ESD PAD VSS
* device instance $1 r0 *1 -65.5,0 NMOSE
M$1 VSS VSS PAD VSS NMOSE L=2u W=500u AS=3523.04p AD=3523.04p PS=689.36u
+ PD=689.36u
.ENDS OSS_NCH_ESD

.SUBCKT OSS_PCH_DRV PAD VDD \$3
* device instance $1 r0 *1 -65.5,0 PMOS
M$1 VDD VDD PAD VDD PMOS L=2u W=200u AS=1573.04p AD=1300p PS=311.36u PD=252u
* device instance $5 r0 *1 -5.5,0 PMOS
M$5 VDD \$3 PAD VDD PMOS L=2u W=300u AS=1950p AD=2223.04p PS=378u PD=437.36u
.ENDS OSS_PCH_DRV

.SUBCKT OSS_PCH_ESD PAD VDD
* device instance $1 r0 *1 -65.5,0 PMOS
M$1 VDD VDD PAD VDD PMOS L=2u W=500u AS=3523.04p AD=3523.04p PS=689.36u
+ PD=689.36u
.ENDS OSS_PCH_ESD
